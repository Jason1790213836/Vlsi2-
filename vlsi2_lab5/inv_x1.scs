// Design: ece6443lib/inv_tb
simulator lang=spectre
global 0
parameters vdd=1 vss=0
include "/ALL_PDK/gpdk045_v_6_0/gpdk045/../models/spectre/gpdk045.scs" section=mc

// ece6443lib/inv_x1/schematic
subckt inv_x1 IN OUT VDD VSS
    NM0 (OUT IN VSS VSS) g45n1svt w=(120n) l=45n nf=1 m=(1)
    PM0 (OUT IN VDD VDD) g45p1svt w=(240n) l=45n nf=1 m=(1)
ends inv_x1

// ece6443lib/inv_tb/schematic
V2 (VSS 0) vsource dc=vss type=dc
V1 (VDD 0) vsource dc=vdd type=dc
V0 (IN 0) vsource type=pulse val0=1 val1=0 period=1u rise=5p fall=5p width=500n
I0 (IN OUT VDD VSS) inv_x1
C0 (OUT 0) capacitor c=2f
simulatorOptions options temp=27
tran tran stop=10u errpreset=moderate step=0.001u
saveOptions options pwr=all currents=all
